.SUBCKT auirgdc0250 1 2 3
* SPICE3 MODEL WITH THERMAL RC NETWORK
**************************************
*      Model Generated by MODPEX     *
*Copyright(c) Symmetry Design Systems*
*         All Rights Reserved        *
*    UNPUBLISHED LICENSED SOFTWARE   *
*   Contains Proprietary Information *
*      Which is The Property of      *
*     SYMMETRY OR ITS LICENSORS      *
*Commercial Use or Resale Restricted *
*   by Symmetry License Agreement    *
**************************************
*Model generated on Nov 29, 12
* MODEL FORMAT: SPICE3
*Symmetry IGBT Model (Version 1.0)
*External Node Designations
*Node 1 -> a
*Node 2 -> g
*Node 3 -> k
M1 9 6 8 8 MSUB L=100u W=100u
.MODEL MSUB NMOS LEVEL=1
+VTO=6.1702 KP=0.912047 LAMBDA=0 CGSO=3.85236e-05
RD 7 9 0.000999241
RS 4 8 0.00127093
Q1 4 7 1 QSUB OFF
.MODEL QSUB PNP
+IS=1e-17 BF=23.301 NF=0.85 VAF=448.285
+IKF=2835.09 ISE=1.04627e-11 NE=1.63177 BR=4.2428
+NR=0.75 VAR=108.347 IKR=1020.91 ISC=9.99594e-12
+NC=1.99441 RB=0.146259 IRB=101.227 RBM=0.00946154
+RE=0.0012401 RC=0.000979748 XTB=0 XTI=3.14402
+EG=1.2 CJC=1.55681e-09 VJC=0.4 MJC=0.557644
+CJE=3.11362e-08 VJE=0.4 MJE=0.9 TF=5.71019e-08
RDS 7 4 1e8
RER 4 3 0.0005
RG 6 2 5.31551
RL 10 11 1
D2 12 11 DCAP
* Default values used in DCAP:
*   RS=0 EG=1.11 XTI=3.0 TT=0
*   BV=infinite IBV=1mA
.MODEL DCAP D IS=1e-32 N=50
+CJO=1.65502e-10 VJ=1.25111 M=0.495918 FC=0.157043
D3 0 11 DL
* Default values used in DL:
*   EG=1.11 XTI=3.0 TT=0 CJO=0
*   RS=0 BV=infinite IBV=1mA
.MODEL DL D IS=1e-10 N=0.4
VFI2 12 0 0
FI2 6 7 VFI2 -1
EV 10 0 7 6 1
CAP 10 13 6.24213e-09
RCAP 10 14 1
D4 0 14 DL
VFI1 13 14 0
FI1 6 7 VFI1 -1
.ENDS auirgdc0250

*SPICE Thermal Model Subcircuit
.SUBCKT auirgdc0250t 5 1

R_RTHERM1         5 4  0.0015
R_RTHERM2         4 3  0.0365
R_RTHERM3         3 2  0.1356
R_RTHERM4         2 1  0.0554
C_CTHERM1         5 1  0.0021
C_CTHERM2         4 1  0.0032
C_CTHERM3         3 1  0.0106
C_CTHERM4         2 1  0.1157

.ENDS auirgdc0250t
